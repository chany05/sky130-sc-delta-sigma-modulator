** Chopper flicker-noise rejection (transient): OTA 1 between two choppers, flicker source in series with the OTA input.
** Case 1: chopper on + flicker.  Case 2: chopper off (clkCh stays low, straight state) + flicker.  Case 3: chopper on, no flicker (numerical floor).
** Same OTA, choppers (4/14/0.35 TGs) and clock generation (clkCh_nd -> nand2 / inv, f_ch = 1.024 MHz) as the top level.
** The loop is closed only at DC (1 GOhm feedback resistors, 1 mF input capacitors: time constant 1e6 s): the bias point is the closed-loop one, the signal path is open loop,
** so the baseband output PSD of case 1 and 2 have the same gain and their ratio is the improvement by the chopper (input referred).
** Flicker: trnoise(0 1u 0.85 66.4u) (NA = 0, NT = 1 us, NALPHA = 0.85, NAMP = 66.4 u), same source as in the modulator simulation.
** Results: /foss/designs/ch_flk_on.txt, ch_flk_off.txt, ch_flk_floor.txt (t, differential output after the 2nd chopper), analyzed by matlab/analyze_ch_flicker.m
.param mc_mm_switch=0
.param mc_pr_switch=0
.include "/foss/pdks/sky130A/libs.tech/ngspice/corners/tt.spice"
.include "/foss/pdks/sky130A/libs.tech/ngspice/r+c/res_typical__cap_typical.spice"
.include "/foss/pdks/sky130A/libs.tech/ngspice/r+c/res_typical__cap_typical__lin.spice"
.include "/foss/pdks/sky130A/libs.tech/ngspice/corners/tt/specialized_cells.spice"
.include /foss/pdks/sky130A/libs.ref/sky130_fd_sc_hd/spice/sky130_fd_sc_hd.spice
.temp 25
.param ch=1
.param fl=1

V2 VDD 0 1.8
V3 VSS 0 0
V1 CMFB_ref 0 0.9
I0 Ibias 0 30.8u

* chopper clock (ch = 0: clkCh_nd stays low -> clkCh = 0, clkCh_b = 1)
Vclk_ch_nd clkCh_nd 0 dc 0 PULSE 0 {1.8*ch} 120n 0.1n 0.1n 488.18n 976.56n
x34 VDD clkCh_nd VSS VSS VDD VDD clkCh_b sky130_fd_sc_hd__nand2_1
x35 clkCh_b VSS VSS VDD VDD clkCh sky130_fd_sc_hd__inv_1

* OTA with input and output chopper
x2 clkCh VDD clkCh_b VSS net2 INn net3 INp chopper
Vfl inp_ota net3 dc 0 trnoise(0 1u 0.85 {66.4u*fl+1e-15})
x1 VDD Ibias net2 OUTp OUTn inp_ota VSS CMFB FullyDiffOTA
x3 clkCh VDD clkCh_b VSS ch_OUTp OUTp ch_OUTn OUTn chopper

* DC bias loop (closed at DC only) and CMFB
* (1 GH inductors, as in tb_ch_OTA, make the transient fail: the inductor companion conductance is below gmin)
Rfb  ch_OUTp INn 1G
Rfb1 INp ch_OUTn 1G
Cin1 INn 0 1m
Cin2 INp 0 1m
R5 OUTp net1 100Meg
R6 net1 OUTn 100Meg
* The ideal CMFB amplifier needs a pole: without Rcm / Ccm the common-mode loop oscillates in the transient and the time step collapses at the first chopper edge.
E1 cmfb_i VSS net1 CMFB_ref 200
Rcm cmfb_i CMFB 10k
Ccm CMFB VSS 2p
C5 OUTp VSS 150f
C7 OUTn VSS 150f
C11 ch_OUTp CMFB_ref 400f
C12 ch_OUTn CMFB_ref 400f

.control
  set wr_singlescale
  option numdgt=7
  * default solver options: run time about 12 min per case for 20 ms; reltol 1e-4 (gear) gives the same chopper-on level and is 5 times slower
  alterparam ch=1
  alterparam fl=1
  reset
  tran 100n 20m
  let vd = v(ch_OUTp)-v(ch_OUTn)
  wrdata /foss/designs/ch_flk_on.txt vd
  alterparam ch=0
  alterparam fl=1
  reset
  tran 100n 20m
  let vd = v(ch_OUTp)-v(ch_OUTn)
  wrdata /foss/designs/ch_flk_off.txt vd
  alterparam ch=1
  alterparam fl=0
  reset
  tran 100n 20m
  let vd = v(ch_OUTp)-v(ch_OUTn)
  wrdata /foss/designs/ch_flk_floor.txt vd
.endc

.subckt FullyDiffOTA VDD Ibias INn OUTp OUTn INp VSS CMFB
*.iopin CMFB
*.ipin INp
*.iopin VDD
*.ipin INn
*.iopin VSS
*.opin OUTp
*.opin OUTn
*.iopin Ibias
XItail net1 Ibias VDD VDD sky130_fd_pr__pfet_01v8 L=0.7 W=2.5 nf=1 ad=0.725 as=0.725 pd=5.58 ps=5.58 nrd=0.116 nrs=0.116 sa=0 sb=0
+ sd=0 mult=9 m=9
XM1 OUTp1 INp net1 net1 sky130_fd_pr__pfet_01v8_lvt L=1.0 W=7.3 nf=1 ad=2.117 as=2.117 pd=15.18 ps=15.18 nrd=0.0397260273972603
+ nrs=0.0397260273972603 sa=0 sb=0 sd=0 mult=10 m=10
XM2 OUTn1 INn net1 net1 sky130_fd_pr__pfet_01v8_lvt L=1.0 W=7.3 nf=1 ad=2.117 as=2.117 pd=15.18 ps=15.18 nrd=0.0397260273972603
+ nrs=0.0397260273972603 sa=0 sb=0 sd=0 mult=10 m=10
XM3 OUTp1 VCM1 VSS VSS sky130_fd_pr__nfet_01v8 L=0.45 W=2.5 nf=1 ad=0.725 as=0.725 pd=5.58 ps=5.58 nrd=0.116 nrs=0.116 sa=0 sb=0
+ sd=0 mult=1
XM4 OUTn1 VCM1 VSS VSS sky130_fd_pr__nfet_01v8 L=0.45 W=2.5 nf=1 ad=0.725 as=0.725 pd=5.58 ps=5.58 nrd=0.116 nrs=0.116 sa=0 sb=0
+ sd=0 mult=1
XM5 OUTp OUTp1 VSS VSS sky130_fd_pr__nfet_01v8 L=0.45 W=5 nf=1 ad=1.45 as=1.45 pd=10.58 ps=10.58 nrd=0.058 nrs=0.058 sa=0 sb=0
+ sd=0 mult=3 m=3
XM6 OUTn OUTn1 VSS VSS sky130_fd_pr__nfet_01v8 L=0.45 W=5 nf=1 ad=1.45 as=1.45 pd=10.58 ps=10.58 nrd=0.058 nrs=0.058 sa=0 sb=0
+ sd=0 mult=3 m=3
XM7 OUTp CMFB VDD VDD sky130_fd_pr__pfet_01v8 L=0.45 W=2.5 nf=1 ad=0.725 as=0.725 pd=5.58 ps=5.58 nrd=0.116 nrs=0.116 sa=0 sb=0
+ sd=0 mult=9 m=9
XM8 OUTn CMFB VDD VDD sky130_fd_pr__pfet_01v8 L=0.45 W=2.5 nf=1 ad=0.725 as=0.725 pd=5.58 ps=5.58 nrd=0.116 nrs=0.116 sa=0 sb=0
+ sd=0 mult=9 m=9
XM9 Ibias Ibias VDD VDD sky130_fd_pr__pfet_01v8 L=0.7 W=2.5 nf=1 ad=0.725 as=0.725 pd=5.58 ps=5.58 nrd=0.116 nrs=0.116 sa=0 sb=0
+ sd=0 mult=9 m=9
XR9 OUTp1 VCM1 VSS sky130_fd_pr__res_xhigh_po_0p35 L=53 mult=1
XR5 VCM1 OUTn1 VSS sky130_fd_pr__res_xhigh_po_0p35 L=53 mult=1
XC5 VCM1 OUTp1 sky130_fd_pr__cap_mim_m3_1 W=2 L=3 MF=1
XC6 OUTp1 VCM1 sky130_fd_pr__cap_mim_m3_2 W=2 L=3 MF=1
XC3 OUTn1 VCM1 sky130_fd_pr__cap_mim_m3_1 W=2 L=3 MF=1
XC4 VCM1 OUTn1 sky130_fd_pr__cap_mim_m3_2 W=2 L=3 MF=1
XR1 net2 OUTp1 VSS sky130_fd_pr__res_high_po W=1 L=2 mult=1
XR2 OUTn1 net3 VSS sky130_fd_pr__res_high_po W=1 L=2 mult=1
XC7 net3 OUTn sky130_fd_pr__cap_mim_m3_1 W=12 L=12 MF=2 m=2
XC8 net3 OUTn sky130_fd_pr__cap_mim_m3_2 W=12 L=12 MF=2 m=2
XC1 OUTp net2 sky130_fd_pr__cap_mim_m3_1 W=12 L=12 MF=2 m=2
XC2 OUTp net2 sky130_fd_pr__cap_mim_m3_2 W=12 L=12 MF=2 m=2
.ends

.subckt chopper clk VDD clk_b VSS OUT1 IN1 OUT2 IN2
x1 clk_b clk VDD VSS IN1 OUT1 TG_switch Wn=4.0 Wp=14.0 LL=0.35
x2 clk clk_b VDD VSS IN1 OUT2 TG_switch Wn=4.0 Wp=14.0 LL=0.35
x3 clk clk_b VDD VSS IN2 OUT1 TG_switch Wn=4.0 Wp=14.0 LL=0.35
x4 clk_b clk VDD VSS IN2 OUT2 TG_switch Wn=4.0 Wp=14.0 LL=0.35
.ends

.subckt TG_switch clk_bar clk VDD VSS n1 n2  Wn=3.0 Wp=10.0 LL=0.35
XM3 n1 clk n2 VSS sky130_fd_pr__nfet_01v8_lvt L=LL W=Wn nf=1 ad='int((1 + 1)/2) * Wn / 1 * 0.29' as='int((1 + 2)/2) * Wn / 1 * 0.29'
+ pd='2*int((1 + 1)/2) * (Wn / 1 + 0.29)' ps='2*int((1 + 2)/2) * (Wn / 1 + 0.29)' nrd='0.29 / Wn ' nrs='0.29 / Wn ' sa=0 sb=0 sd=0 mult=1
XM4 n1 clk_bar n2 VDD sky130_fd_pr__pfet_01v8_lvt L=LL W=Wp nf=1 ad='int((1 + 1)/2) * Wp / 1 * 0.29' as='int((1 + 2)/2) * Wp / 1 * 0.29'
+ pd='2*int((1 + 1)/2) * (Wp / 1 + 0.29)' ps='2*int((1 + 2)/2) * (Wp / 1 + 0.29)' nrd='0.29 / Wp ' nrs='0.29 / Wp ' sa=0 sb=0 sd=0 mult=1
.ends

.end
